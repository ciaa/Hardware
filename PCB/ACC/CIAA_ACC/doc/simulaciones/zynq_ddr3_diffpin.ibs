| / 7\'7
| \ \   Xilinx Inc.
| / /
| \_\/.\   IBIS Models for ZYNQ7 IO
[IBIS ver]   4.2
[File name]   zynq_ddr3.ibs
[File Rev]   2.8
[Date]   Fri June 16 11:15:36 2017
[Source]   Derived from spice models, rev1.0, using
   hspice 2010.03-ENG2
[Notes]   Xilinx IBIS file for ZYNQ7 I/O standards.
   All models are preliminary.
   The version of IBISCHK used is ibischk5.
   Ibis models were generated using S2IBIS3.
[Disclaimer] The data in this file is derived from SPICE simulations using
                 modeling information extracted from the target process.
                 A great deal of care has been taken to provide information
                 that is accurate. This model has been verified by actual silicon
                 measurement.
[Copyright]   Copyright 2012-2016, Xilinx Inc., All rights reserved
|   Component ZYNQ7
[Component]   ZYNQ
[Manufacturer]   Xilinx Inc.
[Package]
|FBG676
|variable   typ   min   max
R_pkg   816.1m   90.6m   1546.3m
L_pkg   5.08nH   0.98nH   9.85nH
C_pkg   2.76pF   1.32pF   4.19pF
[Pin]   signal_name   model_name  R_pin  L_pin  C_pin
A1   GND   GND
A2   IO_L24N_T3_34   NC
A3   IO_L22N_T3_34   NC
A4   IO_L22P_T3_34   NC
A5   IO_L21N_T3_DQS_34   NC
A6   VCCO_34   POWER
A7   IO_L18N_T2_34   NC
A8   IO_L17N_T2_34   NC
A9   IO_L17P_T2_34   NC
A10   IO_L16N_T2_34   NC
A11   GND   GND
A12   IO_L24N_T3_AD15N_35   NC
A13   IO_L24P_T3_AD15P_35   NC
A14   IO_L21N_T3_DQS_AD14N_35   NC
A15   IO_L21P_T3_DQS_AD14P_35   NC
A16   VCCO_35   POWER
A17   IO_L18N_T2_AD13N_35   NC
A18   FIXED_IO_mio[49]   NC
A19   FIXED_IO_mio[53]   NC
A20   FIXED_IO_mio[52]   NC
A21   GND   GND
A22   FIXED_IO_ps_srstb   NC
A23   FIXED_IO_mio[12]   NC
A24   FIXED_IO_mio[8]   NC
A25   FIXED_IO_mio[10]   NC
A26   VCCO_MIO0_500   POWER
B1   IO_L23N_T3_34   NC
B2   IO_L24P_T3_34   NC
B3   VCCO_34   POWER
B4   IO_L20N_T3_34   NC
B5   IO_L20P_T3_34   NC
B6   IO_L21P_T3_DQS_34   NC
B7   IO_L18P_T2_34   NC
B8   GND   GND
B9   IO_L15N_T2_DQS_34   NC
B10   IO_L16P_T2_34   NC
B11   IO_L23N_T3_35   NC
B12   IO_L22N_T3_AD7N_35   NC
B13   VCCO_35   POWER
B14   IO_L20N_T3_AD6N_35   NC
B15   IO_L17N_T2_AD5N_35   NC
B16   IO_L17P_T2_AD5P_35   NC
B17   IO_L18P_T2_AD13P_35   NC
B18   GND   GND
B19   FIXED_IO_mio[47]   NC
B20   FIXED_IO_mio[51]   NC
B21   FIXED_IO_mio[48]   NC
B22   FIXED_IO_mio[50]   NC
B23   VCCO_MIO0_500   POWER
B24   FIXED_IO_ps_clk   NC
B25   FIXED_IO_mio[13]   NC
B26   FIXED_IO_mio[11]   NC
C1   IO_L4N_T0_33   NC
C2   IO_L23P_T3_34   NC
C3   IO_L19N_T3_VREF_34   NC
C4   IO_L19P_T3_34   NC
C5   GND   GND
C6   IO_L14N_T2_SRCC_34   NC
C7   IO_L13N_T2_MRCC_34   NC
C8   IO_L13P_T2_MRCC_34   NC
C9   IO_L15P_T2_DQS_34   NC
C10   VCCO_34   POWER
C11   IO_L23P_T3_35   NC
C12   IO_L22P_T3_AD7P_35   NC
C13   IO_L19N_T3_VREF_35   NC
C14   IO_L20P_T3_AD6P_35   NC
C15   GND   GND
C16   IO_L15N_T2_DQS_AD12N_35   NC
C17   IO_L15P_T2_DQS_AD12P_35   NC
C18   FIXED_IO_mio[45]   NC
C19   FIXED_IO_mio[41]   NC
C20   VCCO_MIO1_501   POWER
C21   FIXED_IO_mio[39]   NC
C22   FIXED_IO_mio[40]   NC
C23   FIXED_IO_ps_porb   NC
C24   FIXED_IO_mio[15]   NC
C25   GND   GND
C26   FIXED_IO_mio[5]   NC
D1   IO_L4P_T0_33   NC
D2   GND   GND
D3   IO_L2N_T0_33   NC
D4   IO_L2P_T0_33   NC
D5   IO_L10N_T1_34   NC
D6   IO_L14P_T2_SRCC_34   NC
D7   VCCO_34   POWER
D8   IO_L8N_T1_34   NC
D9   IO_L8P_T1_34   NC
D10   IO_L2N_T0_AD8N_35   NC
D11   IO_L4N_T0_35   NC
D12   GND   GND
D13   IO_L19P_T3_35   NC
D14   IO_L13N_T2_MRCC_35   NC
D15   IO_L13P_T2_MRCC_35   NC
D16   IO_L16N_T2_35   NC
D17   VCCO_MIO1_501   POWER
D18   FIXED_IO_mio[43]   NC
D19   FIXED_IO_mio[35]   NC
D20   FIXED_IO_mio[37]   NC
D21   FIXED_IO_mio[38]   NC
D22   GND   GND
D23   FIXED_IO_mio[14]   NC
D24   FIXED_IO_mio[9]   NC
D25   FIXED_IO_mio[3]   NC
D26   FIXED_IO_mio[1]   NC
E1   IO_L5N_T0_33   NC
E2   IO_L5P_T0_33   NC
E3   IO_L6N_T0_VREF_33   NC
E4   VCCO_33   POWER
E5   IO_L7N_T1_34   NC
E6   IO_L10P_T1_34   NC
E7   IO_L11N_T1_SRCC_34   NC
E8   IO_L9N_T1_DQS_34   NC
E9   GND   GND
E10   IO_L2P_T0_AD8P_35   NC
E11   IO_L4P_T0_35   NC
E12   IO_L1N_T0_AD0N_35   NC
E13   IO_L6N_T0_VREF_35   NC
E14   VCCO_35   POWER
E15   IO_L14N_T2_AD4N_SRCC_35   NC
E16   IO_L16P_T2_35   NC
E17   FIXED_IO_mio[46]   NC
E18   FIXED_IO_mio[44]   NC
E19   GND   GND
E20   FIXED_IO_mio[29]   NC
E21   FIXED_IO_mio[31]   NC
E22   FIXED_IO_mio[33]   NC
E23   FIXED_IO_mio[7]   NC
E24   VCCO_MIO0_500   POWER
E25   FIXED_IO_mio[2]   NC
E26   FIXED_IO_mio[0]   NC
F1   VCCO_33   POWER
F2   IO_L3N_T0_DQS_33   NC
F3   IO_L6P_T0_33   NC
F4   IO_L1N_T0_33   NC
F5   IO_L7P_T1_34   NC
F6   GND   GND
F7   IO_L12N_T1_MRCC_34   NC
F8   IO_L11P_T1_SRCC_34   NC
F9   IO_L9P_T1_DQS_34   NC
F10   IO_L3N_T0_DQS_AD1N_35   NC
F11   VCCO_35   POWER
F12   IO_L1P_T0_AD0P_35   NC
F13   IO_L6P_T0_35   NC
F14   IO_L11N_T1_SRCC_35   NC
F15   IO_L14P_T2_AD4P_SRCC_35   NC
F16   GND   GND
F17   FIXED_IO_mio[42]   NC
F18   FIXED_IO_mio[27]   NC
F19   FIXED_IO_mio[25]   NC
F20   FIXED_IO_mio[23]   NC
F21   VCCO_MIO1_501   POWER
F22   FIXED_IO_mio[21]   NC
F23   FIXED_IO_mio[6]   NC
F24   FIXED_IO_mio[4]   NC
F25   DDR_dq[1]   SSTL15_DCI_F_PSDDR_MS
F26   GND   GND
G1   IO_L10N_T1_33   NC
G2   IO_L3P_T0_DQS_33   NC
G3   GND   GND
G4   IO_L1P_T0_33   NC
G5   IO_L2N_T0_34   NC
G6   IO_L2P_T0_34   NC
G7   IO_L12P_T1_MRCC_34   NC
G8   VCCO_34   POWER
G9   IO_L3N_T0_DQS_34   NC
G10   IO_L3P_T0_DQS_AD1P_35   NC
G11   IO_L5N_T0_AD9N_35   NC
G12   IO_L5P_T0_AD9P_35   NC
G13   GND   GND
G14   IO_L11P_T1_SRCC_35   NC
G15   IO_L10N_T1_AD11N_35   NC
G16   IO_L10P_T1_AD11P_35   NC
G17   FIXED_IO_mio[17]   NC
G18   VCCO_MIO1_501   POWER
G19   FIXED_IO_mio[19]   NC
G20   FIXED_IO_mio[18]   NC
G21   FIXED_IO_mio[16]   NC
G22   FIXED_IO_mio[22]   NC
G23   GND   GND
G24   DDR_dm[0]   SSTL15_DCI_F_PSDDR_MS
G25   DDR_dqs_n[0]   SSTL15_DCI_F_PSDDR_MS
G26   DDR_dq[3]   SSTL15_DCI_F_PSDDR_MS
H1   IO_L7N_T1_33   NC
H2   IO_L10P_T1_33   NC
H3   IO_L8N_T1_33   NC
H4   IO_L8P_T1_33   NC
H5   VCCO_33   POWER
H6   IO_L4N_T0_34   NC
H7   IO_L4P_T0_34   NC
H8   IO_L6N_T0_VREF_34   NC
H9   PUDC_B   LVCMOS18_F_12_HP
H10   GND   GND
H11   IO_L1N_T0_34   NC
H12   IO_L7N_T1_AD2N_35   NC
H13   IO_L7P_T1_AD2P_35   NC
H14   IO_L12N_T1_MRCC_35   NC
H15   VCCO_35   POWER
H16   IO_0_VRN_35   NC
H17   FIXED_IO_mio[26]   NC
H18   PS_MIO_VREF_501   NC
H19   FIXED_IO_mio[20]   NC
H20   GND   GND
H21   DDR_addr[11]   SSTL15_S_PSDDR
H22   DDR_reset_n   SSTL15_F_PSDDR
H23   DDR_dq[5]   SSTL15_DCI_F_PSDDR_MS
H24   DDR_dqs_p[0]   SSTL15_DCI_F_PSDDR_MS
H25   VCCO_DDR_502   POWER
H26   DDR_dq[4]   SSTL15_DCI_F_PSDDR_MS
J1   IO_L7P_T1_33   NC
J2   VCCO_33   POWER
J3   IO_L12N_T1_MRCC_33   NC
J4   IO_L12P_T1_MRCC_33   NC
J5   IO_L20N_T3_33   NC
J6   IO_L22N_T3_33   NC
J7   GND   GND
J8   IO_L6P_T0_34   NC
J9   IO_L5N_T0_34   NC
J10   IO_L5P_T0_34   NC
J11   IO_L1P_T0_34   NC
J12   VCCO_35   POWER
J13   IO_L8N_T1_AD10N_35   NC
J14   IO_L12P_T1_MRCC_35   NC
J15   IO_L9N_T1_DQS_AD3N_35   NC
J16   FIXED_IO_mio[34]   NC
J17   GND   GND
J18   FIXED_IO_mio[28]   NC
J19   FIXED_IO_mio[24]   NC
J20   DDR_addr[13]   SSTL15_S_PSDDR
J21   DDR_addr[7]   SSTL15_S_PSDDR
J22   VCCO_DDR_502   POWER
J23   DDR_dq[7]   SSTL15_DCI_F_PSDDR_MS
J24   DDR_dq[6]   SSTL15_DCI_F_PSDDR_MS
J25   DDR_dq[2]   SSTL15_DCI_F_PSDDR_MS
J26   DDR_dq[0]   SSTL15_DCI_F_PSDDR_MS
K1   IO_L9N_T1_DQS_33   NC
K2   IO_L9P_T1_DQS_33   NC
K3   IO_L11N_T1_SRCC_33   NC
K4   GND   GND
K5   IO_L20P_T3_33   NC
K6   IO_L22P_T3_33   NC
K7   IO_L24N_T3_33   NC
K8   IO_L24P_T3_33   NC
K9   VCCO_34   POWER
K10   IO_25_VRP_34   NC
K11   IO_0_VRN_34   NC
K12   IO_25_VRP_35   NC
K13   IO_L8P_T1_AD10P_35   NC
K14   GND   GND
K15   IO_L9P_T1_DQS_AD3P_35   NC
K16   FIXED_IO_mio[36]   NC
K17   FIXED_IO_mio[32]   NC
K18   VCCO_MIO1_501   POWER
K19   FIXED_IO_mio[30]   NC
K20   DDR_addr[1]   SSTL15_S_PSDDR
K21   PS_DDR_VREF0_502   NC
K22   DDR_addr[0]   SSTL15_S_PSDDR
K23   DDR_dq[11]   SSTL15_DCI_F_PSDDR_MS
K24   GND   GND
K25   DDR_dm[1]   SSTL15_DCI_F_PSDDR_MS
K26   DDR_dq[8]   SSTL15_DCI_F_PSDDR_MS
L1   GND   GND
L2   IO_L16N_T2_33   NC
L3   IO_L11P_T1_SRCC_33   NC
L4   IO_L14N_T2_SRCC_33   NC
L5   IO_L14P_T2_SRCC_33   NC
L6   VCCO_33   POWER
L7   IO_L19N_T3_VREF_33   NC
L8   IO_L21N_T3_DQS_33   NC
L9   IO_0_VRN_33   NC
L10   GND   GND
L11   VCCINT   POWER
L12   GND   GND
L13   VCCINT   POWER
L14   GND   GND
L15   VCCINT   POWER
L16   GND   GND
L17   VCCPINT   POWER
L18   GND   GND
L19   VCCPAUX   POWER
L20   DDR_addr[6]   SSTL15_S_PSDDR
L21   GND   GND
L22   DDR_addr[3]   SSTL15_S_PSDDR
L23   DDR_dq[9]   SSTL15_DCI_F_PSDDR_MS
L24   DDR_dqs_p[1]   SSTL15_DCI_F_PSDDR_MS
L25   DDR_dqs_n[1]   SSTL15_DCI_F_PSDDR_MS
L26   VCCO_DDR_502   POWER
M1   IO_L18N_T2_33   NC
M2   IO_L16P_T2_33   NC
M3   VCCO_33   POWER
M4   IO_L17N_T2_33   NC
M5   IO_L13N_T2_MRCC_33   NC
M6   IO_L13P_T2_MRCC_33   NC
M7   IO_L19P_T3_33   NC
M8   IO_L21P_T3_DQS_33   NC
M9   GND   GND
M10   VCCAUX_IO_G0   POWER
M11   GND   GND
M12   VCCINT   POWER
M13   GNDADC_0   NC
M14   VCCADC_0   NC
M15   GND   GND
M16   VCCBRAM   POWER
M17   GND   GND
M18   VCCPLL   POWER
M19   GND   GND
M20   DDR_addr[4]   SSTL15_S_PSDDR
M21   PS_DDR_VREF1_502   NC
M22   DDR_addr[10]   SSTL15_S_PSDDR
M23   VCCO_DDR_502   POWER
M24   DDR_dq[14]   SSTL15_DCI_F_PSDDR_MS
M25   DDR_dq[12]   SSTL15_DCI_F_PSDDR_MS
M26   DDR_dq[10]   SSTL15_DCI_F_PSDDR_MS
N1   IO_L18P_T2_33   NC
N2   IO_L15N_T2_DQS_33   NC
N3   IO_L15P_T2_DQS_33   NC
N4   IO_L17P_T2_33   NC
N5   GND   GND
N6   IO_L23N_T3_33   NC
N7   IO_L23P_T3_33   NC
N8   IO_25_VRP_33   NC
N9   VCCAUX   POWER
N10   GND   GND
N11   VCCINT   POWER
N12   GND   GND
N13   VREFN_0   NC
N14   VP_0   NC
N15   VCCINT   POWER
N16   GND   GND
N17   VCCPINT   POWER
N18   GND   GND
N19   VCCPAUX   POWER
N20   VCCO_DDR_502   POWER
N21   DDR_addr[2]   SSTL15_S_PSDDR
N22   DDR_addr[5]   SSTL15_S_PSDDR
N23   DDR_dq[15]   SSTL15_DCI_F_PSDDR_MS
N24   DDR_dq[13]   SSTL15_DCI_F_PSDDR_MS
N25   GND   GND
N26   DDR_dq[18]   SSTL15_DCI_F_PSDDR_MS
P1   GND   GND
P2   GND   GND
P3   GND   GND
P4   GND   GND
P5   GND   GND
P6   GND   GND
P7   GND   GND
P8   VCCAUX   POWER
P9   GND   GND
P10   VCCAUX_IO_G0   POWER
P11   GND   GND
P12   VCCINT   POWER
P13   VN_0   NC
P14   VREFP_0   NC
P15   GND   GND
P16   VCCBRAM   POWER
P17   GND   GND
P18   VCCPINT   POWER
P19   GND   GND
P20   DDR_addr[12]   SSTL15_S_PSDDR
P21   DDR_ck_n   SSTL15_F_PSDDR
P22   GND   GND
P23   DDR_dq[19]   SSTL15_DCI_F_PSDDR_MS
P24   DDR_dq[17]   SSTL15_DCI_F_PSDDR_MS
P25   DDR_dqs_p[2]   SSTL15_DCI_F_PSDDR_MS
P26   DDR_dm[2]   SSTL15_DCI_F_PSDDR_MS
R1   MGTXTXN3_112   NC
R2   MGTXTXP3_112   NC
R3   GND   GND
R4   MGTAVCC   POWER
R5   MGTREFCLK0N_112   NC
R6   MGTREFCLK0P_112   NC
R7   GND   GND
R8   INIT_B_0   LVCMOS18_F_12_HR
R9   VCCAUX   POWER
R10   GND   GND
R11   VCCINT   POWER
R12   GND   GND
R13   DXN_0   NC
R14   DXP_0   NC
R15   VCCINT   POWER
R16   GND   GND
R17   VCCPINT   POWER
R18   GND   GND
R19   VCCPAUX   POWER
R20   DDR_addr[14]   SSTL15_S_PSDDR
R21   DDR_ck_p   SSTL15_F_PSDDR
R22   DDR_ba[2]   SSTL15_S_PSDDR
R23   DDR_dq[23]   SSTL15_DCI_F_PSDDR_MS
R24   VCCO_DDR_502   POWER
R25   DDR_dqs_n[2]   SSTL15_DCI_F_PSDDR_MS
R26   DDR_dq[16]   SSTL15_DCI_F_PSDDR_MS
T1   GND   GND
T2   MGTAVTT   POWER
T3   MGTXRXN3_112   NC
T4   MGTXRXP3_112   NC
T5   GND   GND
T6   MGTAVCC   POWER
T7   CFGBVS_0   LVCMOS18_F_12_HR
T8   VCCAUX   POWER
T9   GND   GND
T10   VCCAUX_IO_G0   POWER
T11   GND   GND
T12   VCCINT   POWER
T13   GND   GND
T14   VCCINT   POWER
T15   GND   GND
T16   VCCBRAM   POWER
T17   GND   GND
T18   VCCPINT   POWER
T19   GND   GND
T20   DDR_addr[8]   SSTL15_S_PSDDR
T21   VCCO_DDR_502   POWER
T22   DDR_ba[1]   SSTL15_S_PSDDR
T23   DDR_dq[22]   SSTL15_DCI_F_PSDDR_MS
T24   DDR_dq[20]   SSTL15_DCI_F_PSDDR_MS
T25   DDR_dq[21]   SSTL15_DCI_F_PSDDR_MS
T26   GND   GND
U1   MGTXTXN2_112   NC
U2   MGTXTXP2_112   NC
U3   GND   GND
U4   MGTAVCC   POWER
U5   MGTREFCLK1N_112   NC
U6   MGTREFCLK1P_112   NC
U7   GND   GND
U8   RSVDVCC3   NC
U9   VCCAUX   POWER
U10   GND   GND
U11   VCCINT   POWER
U12   GND   GND
U13   VCCINT   POWER
U14   GND   GND
U15   VCCINT   POWER
U16   GND   GND
U17   VCCPINT   POWER
U18   GND   GND
U19   VCCPAUX   POWER
U20   DDR_addr[9]   SSTL15_S_PSDDR
U21   DDR_cke   SSTL15_S_PSDDR
U22   DDR_ba[0]   SSTL15_S_PSDDR
U23   GND   GND
U24   DDR_dq[26]   SSTL15_DCI_F_PSDDR_MS
U25   DDR_dq[27]   SSTL15_DCI_F_PSDDR_MS
U26   DDR_dq[25]   SSTL15_DCI_F_PSDDR_MS
V1   GND   GND
V2   MGTAVTT   POWER
V3   MGTXRXN2_112   NC
V4   MGTXRXP2_112   NC
V5   GND   GND
V6   MGTVCCAUX   POWER
V7   GND   GND
V8   RSVDVCC2   NC
V9   PROGRAM_B_0   LVCMOS18_F_12_HR
V10   VCCAUX   POWER
V11   TDI_0   LVCMOS18_F_12_HR
V12   VCCO_0   POWER
V13   RSVDGND   GND
V14   VCCO_0   POWER
V15   VCCBATT_0   LVCMOS18_F_12_HR
V16   VCCBRAM   POWER
V17   GND   GND
V18   IO_25_13   NC
V19   IO_0_13   NC
V20   GND   GND
V21   FIXED_IO_ddr_vrn   NC
V22   DDR_we_n   SSTL15_S_PSDDR
V23   DDR_ras_n   SSTL15_S_PSDDR
V24   DDR_dq[24]   SSTL15_DCI_F_PSDDR_MS
V25   VCCO_DDR_502   POWER
V26   DDR_dm[3]   SSTL15_DCI_F_PSDDR_MS
W1   MGTXTXN1_112   NC
W2   MGTXTXP1_112   NC
W3   GND   GND
W4   MGTAVTT   POWER
W7   GND   GND
W8   RSVDVCC1   NC
W9   DONE_0   LVCMOS18_F_12_HR
W10   TDO_0   LVCMOS18_F_12_HR
W11   TMS_0   LVCMOS18_F_12_HR
W12   TCK_0   LVCMOS18_F_12_HR
W13   IO_L5P_T0_12   NC
W14   IO_0_12   NC
W15   IO_L24N_T3_12   NC
W16   IO_L24P_T3_12   NC
W17   IO_25_12   NC
W18   IO_L23P_T3_13   NC
W19   IO_L23N_T3_13   NC
W20   IO_L19P_T3_13   NC
W21   FIXED_IO_ddr_vrp   NC
W22   VCCO_DDR_502   POWER
W23   DDR_dq[31]   SSTL15_DCI_F_PSDDR_MS
W24   DDR_dqs_p[3]   SSTL15_DCI_F_PSDDR_MS
W25   DDR_dqs_n[3]   SSTL15_DCI_F_PSDDR_MS
W26   DDR_dq[28]   SSTL15_DCI_F_PSDDR_MS
Y1   GND   GND
Y2   MGTAVTT   POWER
Y3   MGTXRXN1_112   NC
Y4   MGTXRXP1_112   NC
Y5   GND   GND
Y6   MGTAVCC   POWER
Y7   GND   GND
Y8   GND   GND
Y9   GND   GND
Y10   IO_L3P_T0_DQS_12   NC
Y11   IO_L1N_T0_12   NC
Y12   IO_L1P_T0_12   NC
Y13   IO_L5N_T0_12   NC
Y14   GND   GND
Y15   IO_L23N_T3_12   NC
Y16   IO_L23P_T3_12   NC
Y17   IO_L19P_T3_12   NC
Y18   IO_L24P_T3_13   NC
Y19   VCCO_13   POWER
Y20   IO_L19N_T3_VREF_13   NC
Y21   DDR_cs_n   SSTL15_S_PSDDR
Y22   DDR_odt   SSTL15_S_PSDDR
Y23   DDR_cas_n   SSTL15_S_PSDDR
Y24   GND   GND
Y25   DDR_dq[29]   SSTL15_DCI_F_PSDDR_MS
Y26   DDR_dq[30]   SSTL15_DCI_F_PSDDR_MS
AA1   MGTXTXN0_112   NC
AA2   MGTXTXP0_112   NC
AA3   GND   GND
AA4   MGTAVCC   POWER
AA7   GND   GND
AA8   MGTAVCC   POWER
AA9   GND   GND
AA10   IO_L3N_T0_DQS_12   NC
AA11   GND   GND
AA12   IO_L6N_T0_VREF_12   NC
AA13   IO_L6P_T0_12   NC
AA14   IO_L22N_T3_12   NC
AA15   IO_L22P_T3_12   NC
AA16   VCCO_12   POWER
AA17   IO_L19N_T3_VREF_12   NC
AA18   IO_L24N_T3_13   NC
AA19   IO_L22P_T3_13   NC
AA20   IO_L20P_T3_13   NC
AA21   GND   GND
AA22   IO_L10P_T1_13   NC
AA23   IO_L10N_T1_13   NC
AA24   IO_L6P_T0_13   NC
AA25   IO_L1P_T0_13   NC
AA26   VCCO_13   POWER
AB1   GND   GND
AB2   MGTAVTT   POWER
AB3   MGTXRXN0_112   NC
AB4   MGTXRXP0_112   NC
AB5   GND   GND
AB6   MGTAVCC   POWER
AB7   MGTAVTTRCAL_112   NC
AB8   MGTRREF_112   NC
AB9   GND   GND
AB10   IO_L4N_T0_12   NC
AB11   IO_L4P_T0_12   NC
AB12   IO_L2P_T0_12   NC
AB13   VCCO_12   POWER
AB14   IO_L14N_T2_SRCC_12   NC
AB15   IO_L14P_T2_SRCC_12   NC
AB16   IO_L20N_T3_12   NC
AB17   IO_L20P_T3_12   NC
AB18   GND   GND
AB19   IO_L22N_T3_13   NC
AB20   IO_L20N_T3_13   NC
AB21   IO_L9P_T1_DQS_13   NC
AB22   IO_L9N_T1_DQS_13   NC
AB23   VCCO_13   POWER
AB24   IO_L6N_T0_VREF_13   NC
AB25   IO_L1N_T0_13   NC
AB26   IO_L2P_T0_13   NC
AC3   GND   GND
AC4   MGTAVTT   POWER
AC7   GND   GND
AC8   MGTAVCC   POWER
AC9   GND   GND
AC10   VCCO_12   POWER
AC11   IO_L2N_T0_12   NC
AC12   IO_L11P_T1_SRCC_12   NC
AC13   IO_L12P_T1_MRCC_12   NC
AC14   IO_L13P_T2_MRCC_12   NC
AC15   GND   GND
AC16   IO_L21N_T3_DQS_12   NC
AC17   IO_L21P_T3_DQS_12   NC
AC18   IO_L21P_T3_DQS_13   NC
AC19   IO_L21N_T3_DQS_13   NC
AC20   VCCO_13   POWER
AC21   IO_L14P_T2_SRCC_13   NC
AC22   IO_L14N_T2_SRCC_13   NC
AC23   IO_L12P_T1_MRCC_13   NC
AC24   IO_L12N_T1_MRCC_13   NC
AC25   GND   GND
AC26   IO_L2N_T0_13   NC
AD1   GND   GND
AD2   MGTAVTT   POWER
AD5   GND   GND
AD6   MGTAVCC   POWER
AD9   GND   GND
AD10   IO_L7N_T1_12   NC
AD11   IO_L11N_T1_SRCC_12   NC
AD12   GND   GND
AD13   IO_L12N_T1_MRCC_12   NC
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[Package Model]   xc7z030_fbg676_grp1
[Diff Pin]   inv_pin   vdiff   tdelay_typ   tdelay_min   tdelay_max
R21   P21  100mV   0   0   0   |DDR_ck   SSTL15_F_PSDDR
H24   G25  100mV   0   0   0   |DDR_dqs[0]   SSTL15_DCI_F_PSDDR_MS
L24   L25  100mV   0   0   0   |DDR_dqs[1]   SSTL15_DCI_F_PSDDR_MS
P25   R25  100mV   0   0   0   |DDR_dqs[2]   SSTL15_DCI_F_PSDDR_MS
W24   W25  100mV   0   0   0   |DDR_dqs[3]   SSTL15_DCI_F_PSDDR_MS
[Model Selector]   SSTL15_DCI_F_PSDDR_MS
SSTL15_DCI_F_PSDDR_IN40_I   Input
SSTL15_DCI_F_PSDDR_IN50_I   Input
SSTL15_DCI_F_PSDDR_IN60_I   Input
SSTL15_DCI_F_PSDDR_O   Output
[Define Package Model]   xc7z030_fbg676_grp1
[Manufacturer]   Xilinx Inc.
[OEM]   xilinx
[Description]   676 ball organic flipchip
|[Number of Sections]   1
[Number of Pins]   443
[Pin Numbers]
|[Pin Name]  Net Number   Net Name   Net's All Pins
AA4   | 1   MGTAVCC   AA4
   |AA8
   |AB6
   |AC8
   |AD6
   |AE8
   |R4
   |T6
   |U4
   |Y6
AB2   | 2   MGTAVTT   AB2
   |AC4
   |AD2
   |AE4
   |AF2
   |AF6
   |T2
   |V2
   |W4
   |Y2
AB7   | 3   MGTAVTTRCAL_112   AB7
V6   | 4   MGTVCCAUX   V6
M14   | 5   VCCADC_0   M14
N9   | 6   VCCAUX   N9
   |P8
   |R9
   |T8
   |U9
   |V10
V15   | 7   VCCBATT_0   V15
M16   | 8   VCCBRAM   M16
   |P16
   |T16
   |V16
L11   | 9   VCCINT   L11
   |L13
   |L15
   |M12
   |N11
   |N15
   |P12
   |R11
   |R15
   |T12
   |T14
   |U11
   |U13
   |U15
V12   | 10   VCCO_0   V12
   |V14
AA16   | 11   VCCO_12   AA16
   |AB13
   |AC10
   |AD17
   |AE14
   |AF11
AA26   | 12   VCCO_13   AA26
   |AB23
   |AC20
   |AE24
   |AF21
   |Y19
E4   | 13   VCCO_33   E4
   |F1
   |H5
   |J2
   |L6
   |M3
A6   | 14   VCCO_34   A6
   |B3
   |C10
   |D7
   |G8
   |K9
A16   | 15   VCCO_35   A16
   |B13
   |E14
   |F11
   |H15
   |J12
H25   | 16   VCCO_DDR_502   H25
   |J22
   |L26
   |M23
   |N20
   |R24
   |T21
   |V25
   |W22
A26   | 17   VCCO_MIO0_500   A26
   |B23
   |E24
C20   | 18   VCCO_MIO1_501   C20
   |D17
   |F21
   |G18
   |K18
L19   | 19   VCCPAUX   L19
   |N19
   |R19
   |U19
L17   | 20   VCCPINT   L17
   |N17
   |P18
   |R17
   |T18
   |U17
M18   | 21   VCCPLL   M18
V13   | 22   CCLK_0   V13
T7   | 23   CFGBVS_0   T7
W9   | 24   DONE_0   W9
R13   | 25   DXN_0   R13
R14   | 26   DXP_0   R14
R8   | 27   INIT_B_0   R8
W14   | 28   IO_0_12   W14
V19   | 29   IO_0_13   V19
L9   | 30   IO_0_VRN_33   L9
K11   | 31   IO_0_VRN_34   K11
H16   | 32   IO_0_VRN_35   H16
W17   | 33   IO_25_12   W17
V18   | 34   IO_25_13   V18
N8   | 35   IO_25_VRP_33   N8
K10   | 36   IO_25_VRP_34   K10
K12   | 37   IO_25_VRP_35   K12
Y11   | 38   IO_L1N_T0_12   Y11
AB25   | 39   IO_L1N_T0_13   AB25
F4   | 40   IO_L1N_T0_33   F4
E12   | 41   IO_L1N_T0_AD0N_35   E12
H11   | 42   IO_L1N_T0_D01_DIN_34   H11
Y12   | 43   IO_L1P_T0_12   Y12
AA25   | 44   IO_L1P_T0_13   AA25
G4   | 45   IO_L1P_T0_33   G4
F12   | 46   IO_L1P_T0_AD0P_35   F12
J11   | 47   IO_L1P_T0_D00_MOSI_34   J11
AC11   | 48   IO_L2N_T0_12   AC11
AC26   | 49   IO_L2N_T0_13   AC26
D3   | 50   IO_L2N_T0_33   D3
D10   | 51   IO_L2N_T0_AD8N_35   D10
G5   | 52   IO_L2N_T0_D03_34   G5
AB12   | 53   IO_L2P_T0_12   AB12
AB26   | 54   IO_L2P_T0_13   AB26
D4   | 55   IO_L2P_T0_33   D4
E10   | 56   IO_L2P_T0_AD8P_35   E10
G6   | 57   IO_L2P_T0_D02_34   G6
AA10   | 58   IO_L3N_T0_DQS_12   AA10
AE26   | 59   IO_L3N_T0_DQS_13   AE26
F2   | 60   IO_L3N_T0_DQS_33   F2
F10   | 61   IO_L3N_T0_DQS_AD1N_35   F10
G9   | 62   IO_L3N_T0_DQS_EMCCLK_34   G9
Y10   | 63   IO_L3P_T0_DQS_12   Y10
AE25   | 64   IO_L3P_T0_DQS_13   AE25
G2   | 65   IO_L3P_T0_DQS_33   G2
G10   | 66   IO_L3P_T0_DQS_AD1P_35   G10
H9   | 67   IO_L3P_T0_DQS_PUDC_B_34   H9
AB10   | 68   IO_L4N_T0_12   AB10
AD26   | 69   IO_L4N_T0_13   AD26
C1   | 70   IO_L4N_T0_33   C1
D11   | 71   IO_L4N_T0_35   D11
H6   | 72   IO_L4N_T0_D05_34   H6
AB11   | 73   IO_L4P_T0_12   AB11
AD25   | 74   IO_L4P_T0_13   AD25
D1   | 75   IO_L4P_T0_33   D1
E11   | 76   IO_L4P_T0_35   E11
H7   | 77   IO_L4P_T0_D04_34   H7
Y13   | 78   IO_L5N_T0_12   Y13
AF25   | 79   IO_L5N_T0_13   AF25
E1   | 80   IO_L5N_T0_33   E1
G11   | 81   IO_L5N_T0_AD9N_35   G11
J9   | 82   IO_L5N_T0_D07_34   J9
W13   | 83   IO_L5P_T0_12   W13
AF24   | 84   IO_L5P_T0_13   AF24
E2   | 85   IO_L5P_T0_33   E2
G12   | 86   IO_L5P_T0_AD9P_35   G12
J10   | 87   IO_L5P_T0_D06_34   J10
H8   | 88   IO_L6N_T0_D08_VREF_34   H8
AA12   | 89   IO_L6N_T0_VREF_12   AA12
AB24   | 90   IO_L6N_T0_VREF_13   AB24
E3   | 91   IO_L6N_T0_VREF_33   E3
E13   | 92   IO_L6N_T0_VREF_35   E13
AA13   | 93   IO_L6P_T0_12   AA13
AA24   | 94   IO_L6P_T0_13   AA24
F3   | 95   IO_L6P_T0_33   F3
F13   | 96   IO_L6P_T0_35   F13
J8   | 97   IO_L6P_T0_FCS_B_34   J8
AD10   | 98   IO_L7N_T1_12   AD10
AF22   | 99   IO_L7N_T1_13   AF22
H1   | 100   IO_L7N_T1_33   H1
H12   | 101   IO_L7N_T1_AD2N_35   H12
E5   | 102   IO_L7N_T1_D10_34   E5
AE10   | 103   IO_L7P_T1_12   AE10
AE22   | 104   IO_L7P_T1_13   AE22
J1   | 105   IO_L7P_T1_33   J1
H13   | 106   IO_L7P_T1_AD2P_35   H13
F5   | 107   IO_L7P_T1_D09_34   F5
AF12   | 108   IO_L8N_T1_12   AF12
AF23   | 109   IO_L8N_T1_13   AF23
H3   | 110   IO_L8N_T1_33   H3
J13   | 111   IO_L8N_T1_AD10N_35   J13
D8   | 112   IO_L8N_T1_D12_34   D8
AE12   | 113   IO_L8P_T1_12   AE12
AE23   | 114   IO_L8P_T1_13   AE23
H4   | 115   IO_L8P_T1_33   H4
K13   | 116   IO_L8P_T1_AD10P_35   K13
D9   | 117   IO_L8P_T1_D11_34   D9
AF10   | 118   IO_L9N_T1_DQS_12   AF10
AB22   | 119   IO_L9N_T1_DQS_13   AB22
K1   | 120   IO_L9N_T1_DQS_33   K1
J15   | 121   IO_L9N_T1_DQS_AD3N_35   J15
E8   | 122   IO_L9N_T1_DQS_D13_34   E8
AE11   | 123   IO_L9P_T1_DQS_12   AE11
AB21   | 124   IO_L9P_T1_DQS_13   AB21
K2   | 125   IO_L9P_T1_DQS_33   K2
F9   | 126   IO_L9P_T1_DQS_34   F9
K15   | 127   IO_L9P_T1_DQS_AD3P_35   K15
AF13   | 128   IO_L10N_T1_12   AF13
AA23   | 129   IO_L10N_T1_13   AA23
G1   | 130   IO_L10N_T1_33   G1
G15   | 131   IO_L10N_T1_AD11N_35   G15
D5   | 132   IO_L10N_T1_D15_34   D5
AE13   | 133   IO_L10P_T1_12   AE13
AA22   | 134   IO_L10P_T1_13   AA22
H2   | 135   IO_L10P_T1_33   H2
G16   | 136   IO_L10P_T1_AD11P_35   G16
E6   | 137   IO_L10P_T1_D14_34   E6
AD11   | 138   IO_L11N_T1_SRCC_12   AD11
AD24   | 139   IO_L11N_T1_SRCC_13   AD24
K3   | 140   IO_L11N_T1_SRCC_33   K3
E7   | 141   IO_L11N_T1_SRCC_34   E7
F14   | 142   IO_L11N_T1_SRCC_35   F14
AC12   | 143   IO_L11P_T1_SRCC_12   AC12
AD23   | 144   IO_L11P_T1_SRCC_13   AD23
L3   | 145   IO_L11P_T1_SRCC_33   L3
F8   | 146   IO_L11P_T1_SRCC_34   F8
G14   | 147   IO_L11P_T1_SRCC_35   G14
AD13   | 148   IO_L12N_T1_MRCC_12   AD13
AC24   | 149   IO_L12N_T1_MRCC_13   AC24
J3   | 150   IO_L12N_T1_MRCC_33   J3
F7   | 151   IO_L12N_T1_MRCC_34   F7
H14   | 152   IO_L12N_T1_MRCC_35   H14
AC13   | 153   IO_L12P_T1_MRCC_12   AC13
AC23   | 154   IO_L12P_T1_MRCC_13   AC23
J4   | 155   IO_L12P_T1_MRCC_33   J4
G7   | 156   IO_L12P_T1_MRCC_34   G7
J14   | 157   IO_L12P_T1_MRCC_35   J14
AD14   | 158   IO_L13N_T2_MRCC_12   AD14
AD21   | 159   IO_L13N_T2_MRCC_13   AD21
M5   | 160   IO_L13N_T2_MRCC_33   M5
C7   | 161   IO_L13N_T2_MRCC_34   C7
D14   | 162   IO_L13N_T2_MRCC_35   D14
AC14   | 163   IO_L13P_T2_MRCC_12   AC14
AD20   | 164   IO_L13P_T2_MRCC_13   AD20
M6   | 165   IO_L13P_T2_MRCC_33   M6
C8   | 166   IO_L13P_T2_MRCC_34   C8
D15   | 167   IO_L13P_T2_MRCC_35   D15
E15   | 168   IO_L14N_T2_AD4N_SRCC_35   E15
AB14   | 169   IO_L14N_T2_SRCC_12   AB14
AC22   | 170   IO_L14N_T2_SRCC_13   AC22
L4   | 171   IO_L14N_T2_SRCC_33   L4
C6   | 172   IO_L14N_T2_SRCC_34   C6
F15   | 173   IO_L14P_T2_AD4P_SRCC_35   F15
AB15   | 174   IO_L14P_T2_SRCC_12   AB15
AC21   | 175   IO_L14P_T2_SRCC_13   AC21
L5   | 176   IO_L14P_T2_SRCC_33   L5
D6   | 177   IO_L14P_T2_SRCC_34   D6
AD15   | 178   IO_L15N_T2_DQS_12   AD15
AF20   | 179   IO_L15N_T2_DQS_13   AF20
N2   | 180   IO_L15N_T2_DQS_33   N2
C16   | 181   IO_L15N_T2_DQS_AD12N_35   C16
B9   | 182   IO_L15N_T2_DQS_DOUT_CSO_B_34   B9
AD16   | 183   IO_L15P_T2_DQS_12   AD16
AF19   | 184   IO_L15P_T2_DQS_13   AF19
N3   | 185   IO_L15P_T2_DQS_33   N3
C17   | 186   IO_L15P_T2_DQS_AD12P_35   C17
C9   | 187   IO_L15P_T2_DQS_RDWR_B_34   C9
AF14   | 188   IO_L16N_T2_12   AF14
AE21   | 189   IO_L16N_T2_13   AE21
L2   | 190   IO_L16N_T2_33   L2
D16   | 191   IO_L16N_T2_35   D16
A10   | 192   IO_L16N_T2_A15_D31_34   A10
AF15   | 193   IO_L16P_T2_12   AF15
AE20   | 194   IO_L16P_T2_13   AE20
M2   | 195   IO_L16P_T2_33   M2
E16   | 196   IO_L16P_T2_35   E16
B10   | 197   IO_L16P_T2_CSI_B_34   B10
AE15   | 198   IO_L17N_T2_12   AE15
AD19   | 199   IO_L17N_T2_13   AD19
M4   | 200   IO_L17N_T2_33   M4
A8   | 201   IO_L17N_T2_A13_D29_34   A8
B15   | 202   IO_L17N_T2_AD5N_35   B15
AE16   | 203   IO_L17P_T2_12   AE16
AD18   | 204   IO_L17P_T2_13   AD18
N4   | 205   IO_L17P_T2_33   N4
A9   | 206   IO_L17P_T2_A14_D30_34   A9
B16   | 207   IO_L17P_T2_AD5P_35   B16
AF17   | 208   IO_L18N_T2_12   AF17
AF18   | 209   IO_L18N_T2_13   AF18
M1   | 210   IO_L18N_T2_33   M1
A7   | 211   IO_L18N_T2_A11_D27_34   A7
A17   | 212   IO_L18N_T2_AD13N_35   A17
AE17   | 213   IO_L18P_T2_12   AE17
AE18   | 214   IO_L18P_T2_13   AE18
N1   | 215   IO_L18P_T2_33   N1
B7   | 216   IO_L18P_T2_A12_D28_34   B7
B17   | 217   IO_L18P_T2_AD13P_35   B17
C3   | 218   IO_L19N_T3_A09_D25_VREF_34   C3
AA17   | 219   IO_L19N_T3_VREF_12   AA17
Y20   | 220   IO_L19N_T3_VREF_13   Y20
L7   | 221   IO_L19N_T3_VREF_33   L7
C13   | 222   IO_L19N_T3_VREF_35   C13
Y17   | 223   IO_L19P_T3_12   Y17
W20   | 224   IO_L19P_T3_13   W20
M7   | 225   IO_L19P_T3_33   M7
D13   | 226   IO_L19P_T3_35   D13
C4   | 227   IO_L19P_T3_A10_D26_34   C4
AB16   | 228   IO_L20N_T3_12   AB16
AB20   | 229   IO_L20N_T3_13   AB20
J5   | 230   IO_L20N_T3_33   J5
B4   | 231   IO_L20N_T3_A07_D23_34   B4
B14   | 232   IO_L20N_T3_AD6N_35   B14
AB17   | 233   IO_L20P_T3_12   AB17
AA20   | 234   IO_L20P_T3_13   AA20
K5   | 235   IO_L20P_T3_33   K5
B5   | 236   IO_L20P_T3_A08_D24_34   B5
C14   | 237   IO_L20P_T3_AD6P_35   C14
AC16   | 238   IO_L21N_T3_DQS_12   AC16
AC19   | 239   IO_L21N_T3_DQS_13   AC19
L8   | 240   IO_L21N_T3_DQS_33   L8
A5   | 241   IO_L21N_T3_DQS_A06_D22_34   A5
A14   | 242   IO_L21N_T3_DQS_AD14N_35   A14
AC17   | 243   IO_L21P_T3_DQS_12   AC17
AC18   | 244   IO_L21P_T3_DQS_13   AC18
M8   | 245   IO_L21P_T3_DQS_33   M8
B6   | 246   IO_L21P_T3_DQS_34   B6
A15   | 247   IO_L21P_T3_DQS_AD14P_35   A15
AA14   | 248   IO_L22N_T3_12   AA14
AB19   | 249   IO_L22N_T3_13   AB19
J6   | 250   IO_L22N_T3_33   J6
A3   | 251   IO_L22N_T3_A04_D20_34   A3
B12   | 252   IO_L22N_T3_AD7N_35   B12
AA15   | 253   IO_L22P_T3_12   AA15
AA19   | 254   IO_L22P_T3_13   AA19
K6   | 255   IO_L22P_T3_33   K6
A4   | 256   IO_L22P_T3_A05_D21_34   A4
C12   | 257   IO_L22P_T3_AD7P_35   C12
Y15   | 258   IO_L23N_T3_12   Y15
W19   | 259   IO_L23N_T3_13   W19
N6   | 260   IO_L23N_T3_33   N6
B11   | 261   IO_L23N_T3_35   B11
B1   | 262   IO_L23N_T3_A02_D18_34   B1
Y16   | 263   IO_L23P_T3_12   Y16
W18   | 264   IO_L23P_T3_13   W18
N7   | 265   IO_L23P_T3_33   N7
C11   | 266   IO_L23P_T3_35   C11
C2   | 267   IO_L23P_T3_A03_D19_34   C2
W15   | 268   IO_L24N_T3_12   W15
AA18   | 269   IO_L24N_T3_13   AA18
K7   | 270   IO_L24N_T3_33   K7
A2   | 271   IO_L24N_T3_A00_D16_34   A2
A12   | 272   IO_L24N_T3_AD15N_35   A12
W16   | 273   IO_L24P_T3_12   W16
Y18   | 274   IO_L24P_T3_13   Y18
K8   | 275   IO_L24P_T3_33   K8
B2   | 276   IO_L24P_T3_A01_D17_34   B2
A13   | 277   IO_L24P_T3_AD15P_35   A13
U8   | 278   M0_0   U8
V8   | 279   M1_0   V8
W8   | 280   M2_0   W8
R5   | 281   MGTREFCLK0N_112   R5
R6   | 282   MGTREFCLK0P_112   R6
U5   | 283   MGTREFCLK1N_112   U5
U6   | 284   MGTREFCLK1P_112   U6
AB8   | 285   MGTRREF_112   AB8
AB3   | 286   MGTXRXN0_112   AB3
Y3   | 287   MGTXRXN1_112   Y3
V3   | 288   MGTXRXN2_112   V3
T3   | 289   MGTXRXN3_112   T3
AB4   | 290   MGTXRXP0_112   AB4
Y4   | 291   MGTXRXP1_112   Y4
V4   | 292   MGTXRXP2_112   V4
T4   | 293   MGTXRXP3_112   T4
AA1   | 294   MGTXTXN0_112   AA1
W1   | 295   MGTXTXN1_112   W1
U1   | 296   MGTXTXN2_112   U1
R1   | 297   MGTXTXN3_112   R1
AA2   | 298   MGTXTXP0_112   AA2
W2   | 299   MGTXTXP1_112   W2
U2   | 300   MGTXTXP2_112   U2
R2   | 301   MGTXTXP3_112   R2
V9   | 302   PROGRAM_B_0   V9
B24   | 303   PS_CLK_500   B24
K22   | 304   PS_DDR_A0_502   K22
K20   | 305   PS_DDR_A1_502   K20
N21   | 306   PS_DDR_A2_502   N21
L22   | 307   PS_DDR_A3_502   L22
M20   | 308   PS_DDR_A4_502   M20
N22   | 309   PS_DDR_A5_502   N22
L20   | 310   PS_DDR_A6_502   L20
J21   | 311   PS_DDR_A7_502   J21
T20   | 312   PS_DDR_A8_502   T20
U20   | 313   PS_DDR_A9_502   U20
M22   | 314   PS_DDR_A10_502   M22
H21   | 315   PS_DDR_A11_502   H21
P20   | 316   PS_DDR_A12_502   P20
J20   | 317   PS_DDR_A13_502   J20
R20   | 318   PS_DDR_A14_502   R20
U22   | 319   PS_DDR_BA0_502   U22
T22   | 320   PS_DDR_BA1_502   T22
R22   | 321   PS_DDR_BA2_502   R22
Y23   | 322   PS_DDR_CAS_B_502   Y23
U21   | 323   PS_DDR_CKE_502   U21
P21   | 324   PS_DDR_CKN_502   P21
R21   | 325   PS_DDR_CKP_502   R21
Y21   | 326   PS_DDR_CS_B_502   Y21
G24   | 327   PS_DDR_DM0_502   G24
K25   | 328   PS_DDR_DM1_502   K25
P26   | 329   PS_DDR_DM2_502   P26
V26   | 330   PS_DDR_DM3_502   V26
J26   | 331   PS_DDR_DQ0_502   J26
F25   | 332   PS_DDR_DQ1_502   F25
J25   | 333   PS_DDR_DQ2_502   J25
G26   | 334   PS_DDR_DQ3_502   G26
H26   | 335   PS_DDR_DQ4_502   H26
H23   | 336   PS_DDR_DQ5_502   H23
J24   | 337   PS_DDR_DQ6_502   J24
J23   | 338   PS_DDR_DQ7_502   J23
K26   | 339   PS_DDR_DQ8_502   K26
L23   | 340   PS_DDR_DQ9_502   L23
M26   | 341   PS_DDR_DQ10_502   M26
K23   | 342   PS_DDR_DQ11_502   K23
M25   | 343   PS_DDR_DQ12_502   M25
N24   | 344   PS_DDR_DQ13_502   N24
M24   | 345   PS_DDR_DQ14_502   M24
N23   | 346   PS_DDR_DQ15_502   N23
R26   | 347   PS_DDR_DQ16_502   R26
P24   | 348   PS_DDR_DQ17_502   P24
N26   | 349   PS_DDR_DQ18_502   N26
P23   | 350   PS_DDR_DQ19_502   P23
T24   | 351   PS_DDR_DQ20_502   T24
T25   | 352   PS_DDR_DQ21_502   T25
T23   | 353   PS_DDR_DQ22_502   T23
R23   | 354   PS_DDR_DQ23_502   R23
V24   | 355   PS_DDR_DQ24_502   V24
U26   | 356   PS_DDR_DQ25_502   U26
U24   | 357   PS_DDR_DQ26_502   U24
U25   | 358   PS_DDR_DQ27_502   U25
W26   | 359   PS_DDR_DQ28_502   W26
Y25   | 360   PS_DDR_DQ29_502   Y25
Y26   | 361   PS_DDR_DQ30_502   Y26
W23   | 362   PS_DDR_DQ31_502   W23
G25   | 363   PS_DDR_DQS_N0_502   G25
L25   | 364   PS_DDR_DQS_N1_502   L25
R25   | 365   PS_DDR_DQS_N2_502   R25
W25   | 366   PS_DDR_DQS_N3_502   W25
H24   | 367   PS_DDR_DQS_P0_502   H24
L24   | 368   PS_DDR_DQS_P1_502   L24
P25   | 369   PS_DDR_DQS_P2_502   P25
W24   | 370   PS_DDR_DQS_P3_502   W24
H22   | 371   PS_DDR_DRST_B_502   H22
Y22   | 372   PS_DDR_ODT_502   Y22
V23   | 373   PS_DDR_RAS_B_502   V23
K21   | 374   PS_DDR_VREF0_502   K21
M21   | 375   PS_DDR_VREF1_502   M21
V21   | 376   PS_DDR_VRN_502   V21
W21   | 377   PS_DDR_VRP_502   W21
V22   | 378   PS_DDR_WE_B_502   V22
E26   | 379   PS_MIO0_500   E26
D26   | 380   PS_MIO1_500   D26
E25   | 381   PS_MIO2_500   E25
D25   | 382   PS_MIO3_500   D25
F24   | 383   PS_MIO4_500   F24
C26   | 384   PS_MIO5_500   C26
F23   | 385   PS_MIO6_500   F23
E23   | 386   PS_MIO7_500   E23
A24   | 387   PS_MIO8_500   A24
D24   | 388   PS_MIO9_500   D24
A25   | 389   PS_MIO10_500   A25
B26   | 390   PS_MIO11_500   B26
A23   | 391   PS_MIO12_500   A23
B25   | 392   PS_MIO13_500   B25
D23   | 393   PS_MIO14_500   D23
C24   | 394   PS_MIO15_500   C24
G21   | 395   PS_MIO16_501   G21
G17   | 396   PS_MIO17_501   G17
G20   | 397   PS_MIO18_501   G20
G19   | 398   PS_MIO19_501   G19
H19   | 399   PS_MIO20_501   H19
F22   | 400   PS_MIO21_501   F22
G22   | 401   PS_MIO22_501   G22
F20   | 402   PS_MIO23_501   F20
J19   | 403   PS_MIO24_501   J19
F19   | 404   PS_MIO25_501   F19
H17   | 405   PS_MIO26_501   H17
F18   | 406   PS_MIO27_501   F18
J18   | 407   PS_MIO28_501   J18
E20   | 408   PS_MIO29_501   E20
K19   | 409   PS_MIO30_501   K19
E21   | 410   PS_MIO31_501   E21
K17   | 411   PS_MIO32_501   K17
E22   | 412   PS_MIO33_501   E22
J16   | 413   PS_MIO34_501   J16
D19   | 414   PS_MIO35_501   D19
K16   | 415   PS_MIO36_501   K16
D20   | 416   PS_MIO37_501   D20
D21   | 417   PS_MIO38_501   D21
C21   | 418   PS_MIO39_501   C21
C22   | 419   PS_MIO40_501   C22
C19   | 420   PS_MIO41_501   C19
F17   | 421   PS_MIO42_501   F17
D18   | 422   PS_MIO43_501   D18
E18   | 423   PS_MIO44_501   E18
C18   | 424   PS_MIO45_501   C18
E17   | 425   PS_MIO46_501   E17
B19   | 426   PS_MIO47_501   B19
B21   | 427   PS_MIO48_501   B21
A18   | 428   PS_MIO49_501   A18
B22   | 429   PS_MIO50_501   B22
B20   | 430   PS_MIO51_501   B20
A20   | 431   PS_MIO52_501   A20
A19   | 432   PS_MIO53_501   A19
H18   | 433   PS_MIO_VREF_501   H18
C23   | 434   PS_POR_B_500   C23
A22   | 435   PS_SRST_B_501   A22
W12   | 436   TCK_0   W12
V11   | 437   TDI_0   V11
W10   | 438   TDO_0   W10
W11   | 439   TMS_0   W11
P13   | 440   VN_0   P13
N14   | 441   VP_0   N14
N13   | 442   VREFN_0   N13
P14   | 443   VREFP_0   P14
[Model Data]
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[End Model Data]
[End Package Model]
| Models and submodels in the file (8): LVCMOS18_F_12_HP (I/O), LVCMOS18_F_12_HR (I/O), SSTL15_DCI_F_PSDDR_IN40_I (Input), SSTL15_DCI_F_PSDDR_IN50_I (Input), SSTL15_DCI_F_PSDDR_IN60_I (Input), SSTL15_DCI_F_PSDDR_O (Output), SSTL15_F_PSDDR (I/O), SSTL15_S_PSDDR (I/O)
